*** SPICE deck for cell SUM_V0{lay} from library HW5_NOR
*** Created on Mon Apr 06, 2026 13:06:16
*** Last revised on Tue Apr 07, 2026 08:29:44
*** Written on Tue Apr 07, 2026 08:34:47 by Electric VLSI Design System, version 9.07
*** Layout tech: mocmos, foundry MOSIS
*** UC SPICE *** , MIN_RESIST 4.0, MIN_CAPAC 0.1FF
*CMOS/BULK-NWELL (PRELIMINARY PARAMETERS)
.OPTIONS NOMOD DEFL=3UM DEFW=3UM DEFAD=70P DEFAS=70P LIMPTS=1000
+ITL5=0 RELTOL=0.01 ABSTOL=500PA VNTOL=500UV LVLTIM=2
+LVLCOD=1
.MODEL N NMOS LEVEL=1
+KP=60E-6 VTO=0.7 GAMMA=0.3 LAMBDA=0.05 PHI=0.6
+LD=0.4E-6 TOX=40E-9 CGSO=2.0E-10 CGDO=2.0E-10 CJ=.2MF/M^2
.MODEL P PMOS LEVEL=1
+KP=20E-6 VTO=0.7 GAMMA=0.4 LAMBDA=0.05 PHI=0.6
+LD=0.6E-6 TOX=40E-9 CGSO=3.0E-10 CGDO=3.0E-10 CJ=.2MF/M^2
.MODEL DIFFCAP D CJO=.2MF/M^2

*** TOP LEVEL CELL: SUM_V0{lay}
Mnmos@0 gnd A net@2 gnd N L=0.7U W=2.1U AS=3.491P AD=5.451P PS=6.475U PD=11.55U
Mnmos@1 net@2 net@6 gnd gnd N L=0.7U W=2.1U AS=5.451P AD=3.491P PS=11.55U PD=6.475U
Mnmos@2 net@14 B net@2 gnd N L=0.7U W=2.1U AS=3.491P AD=3.001P PS=6.475U PD=4.9U
Mnmos@3 net@2 net@18 net@14 gnd N L=0.7U W=2.1U AS=3.001P AD=3.491P PS=4.9U PD=6.475U
Mnmos@4 gnd Ci net@45 gnd N L=0.7U W=2.1U AS=3.491P AD=5.451P PS=6.475U PD=11.55U
Mnmos@5 net@45 net@76 gnd gnd N L=0.7U W=2.1U AS=5.451P AD=3.491P PS=11.55U PD=6.475U
Mnmos@6 OUT net@14 net@45 gnd N L=0.7U W=2.1U AS=3.491P AD=3.001P PS=6.475U PD=4.9U
Mnmos@7 net@45 net@50 OUT gnd N L=0.7U W=2.1U AS=3.001P AD=3.491P PS=4.9U PD=6.475U
Mnmos@8 net@18 A gnd gnd N L=0.7U W=1.05U AS=5.451P AD=3.491P PS=11.55U PD=7.7U
Mnmos@9 net@6 B gnd gnd N L=0.7U W=1.05U AS=5.451P AD=3.491P PS=11.55U PD=7.7U
Mnmos@10 net@76 net@14 gnd gnd N L=0.7U W=1.05U AS=5.451P AD=3.491P PS=11.55U PD=7.7U
Mnmos@11 net@50 Ci gnd gnd N L=0.7U W=1.05U AS=5.451P AD=3.491P PS=11.55U PD=7.7U
Mpmos@0 net@0 A vdd vdd P L=0.7U W=2.8U AS=7.534P AD=1.929P PS=14.569U PD=4.725U
Mpmos@1 net@14 net@6 net@0 vdd P L=0.7U W=2.8U AS=1.929P AD=3.001P PS=4.725U PD=4.9U
Mpmos@2 net@12 B net@14 vdd P L=0.7U W=2.8U AS=3.001P AD=1.991P PS=4.9U PD=4.55U
Mpmos@3 vdd net@18 net@12 vdd P L=0.7U W=2.8U AS=1.991P AD=7.534P PS=4.55U PD=14.569U
Mpmos@4 net@40 Ci vdd vdd P L=0.7U W=2.8U AS=7.534P AD=1.929P PS=14.569U PD=4.725U
Mpmos@5 OUT net@76 net@40 vdd P L=0.7U W=2.8U AS=1.929P AD=3.001P PS=4.725U PD=4.9U
Mpmos@6 net@44 net@14 OUT vdd P L=0.7U W=2.8U AS=3.001P AD=1.991P PS=4.9U PD=4.55U
Mpmos@7 vdd net@50 net@44 vdd P L=0.7U W=2.8U AS=1.991P AD=7.534P PS=4.55U PD=14.569U
Mpmos@8 net@18 A vdd vdd P L=0.7U W=1.4U AS=7.534P AD=3.491P PS=14.569U PD=7.7U
Mpmos@9 net@6 B vdd vdd P L=0.7U W=1.4U AS=7.534P AD=3.491P PS=14.569U PD=7.7U
Mpmos@10 net@76 net@14 vdd vdd P L=0.7U W=1.4U AS=7.534P AD=3.491P PS=14.569U PD=7.7U
Mpmos@11 net@50 Ci vdd vdd P L=0.7U W=1.4U AS=7.534P AD=3.491P PS=14.569U PD=7.7U
.END
