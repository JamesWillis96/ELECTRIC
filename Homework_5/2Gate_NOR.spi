*** SPICE deck for cell 2Gate_NOR{lay} from library HW5_NOR
*** Created on Sun Mar 29, 2026 11:47:44
*** Last revised on Sun Mar 29, 2026 12:40:25
*** Written on Sun Mar 29, 2026 15:11:07 by Electric VLSI Design System, version 9.08
*** Layout tech: mocmos, foundry MOSIS
*** UC SPICE *** , MIN_RESIST 4.0, MIN_CAPAC 0.1FF
***    P-Active:	areacap=0.9FF/um^2,	edgecap=0.0FF/um,	res=2.5ohms/sq
***    N-Active:	areacap=0.9FF/um^2,	edgecap=0.0FF/um,	res=3.0ohms/sq
***    Polysilicon-1:	areacap=0.1467FF/um^2,	edgecap=0.0608FF/um,	res=6.2ohms/sq
***    Polysilicon-2:	areacap=1.0FF/um^2,	edgecap=0.0FF/um,	res=50.0ohms/sq
***    Transistor-Poly:	areacap=0.09FF/um^2,	edgecap=0.0FF/um,	res=2.5ohms/sq
***    Poly-Cut:	areacap=0.0FF/um^2,	edgecap=0.0FF/um,	res=2.2ohms/sq
***    Active-Cut:	areacap=0.0FF/um^2,	edgecap=0.0FF/um,	res=2.5ohms/sq
***    Metal-1:	areacap=0.1209FF/um^2,	edgecap=0.1104FF/um,	res=0.078ohms/sq
***    Via1:	areacap=0.0FF/um^2,	edgecap=0.0FF/um,	res=1.0ohms/sq
***    Metal-2:	areacap=0.0843FF/um^2,	edgecap=0.0974FF/um,	res=0.078ohms/sq
***    Via2:	areacap=0.0FF/um^2,	edgecap=0.0FF/um,	res=0.9ohms/sq
***    Metal-3:	areacap=0.0843FF/um^2,	edgecap=0.0974FF/um,	res=0.078ohms/sq
***    Via3:	areacap=0.0FF/um^2,	edgecap=0.0FF/um,	res=0.8ohms/sq
***    Metal-4:	areacap=0.0843FF/um^2,	edgecap=0.0974FF/um,	res=0.078ohms/sq
***    Via4:	areacap=0.0FF/um^2,	edgecap=0.0FF/um,	res=0.8ohms/sq
***    Metal-5:	areacap=0.0843FF/um^2,	edgecap=0.0974FF/um,	res=0.078ohms/sq
***    Via5:	areacap=0.0FF/um^2,	edgecap=0.0FF/um,	res=0.8ohms/sq
***    Metal-6:	areacap=0.0423FF/um^2,	edgecap=0.1273FF/um,	res=0.036ohms/sq
***    Hi-Res:	areacap=0.0FF/um^2,	edgecap=0.0FF/um,	res=1.0ohms/sq
* Model cards described in this file:
.include 'C:\Users\jbwil\OneDrive - University of Wyoming\Documents\ELECTRIC FILES\AMI0p5BSIM.txt'

*** TOP LEVEL CELL: 2Gate_NOR{lay}
Mnmos@4 OUT A#0nmos@4_poly-right gnd gnd N L=0.7U W=1.05U AS=3.43P AD=2.45P PS=7.7U PD=5.367U
Mnmos@5 gnd B#0nmos@5_poly-right OUT gnd N L=0.7U W=1.05U AS=2.45P AD=3.43P PS=5.367U PD=7.7U
Mpmos@4 net@36 A#1pmos@4_poly-left vdd vdd P L=0.7U W=1.4U AS=6.86P AD=1.439P PS=15.05U PD=3.675U
Mpmos@5 OUT B#2pmos@5_poly-left net@36 vdd P L=0.7U W=1.4U AS=1.439P AD=2.45P PS=3.675U PD=5.367U
** Extracted Parasitic Capacitors ***
C0 OUT 0 2.921fF
C1 A 0 0.222fF
C2 A#1pmos@4_poly-left 0 0.196fF
C3 A#3pin@9_polysilicon-1 0 0.249fF
C4 B 0 0.216fF
C5 B#2pmos@5_poly-left 0 0.157fF

** Output capacitance **
Cout OUT 0 10fF
** Extracted Parasitic Resistors ***
R0 A#0nmos@4_poly-right A#0nmos@4_poly-right##0 5.425
R1 A#0nmos@4_poly-right##0 A 5.425
R2 A A##0 7.75
C6 A##0 0 0.131fF
R3 A##0 A#3pin@9_polysilicon-1 7.75
R4 A#1pmos@4_poly-left A#3pin@9_polysilicon-1 9.3
R5 B#0nmos@5_poly-right B 4.65
R6 B#2pmos@5_poly-left B#2pmos@5_poly-left##0 9.3
C7 B#2pmos@5_poly-left##0 0 0.157fF
R7 B#2pmos@5_poly-left##0 B 9.3

* --- Voltage Supplies ---
Vdd vdd 0 5V
V_A A 0 PULSE(0 5 2n 100p 100p 5n 10n)
V_B B 0 PULSE(0 5 12n 100p 100p 5n 30n)

* --- Simulation Command ---
.tran 0 40n

* --- Rise Times (10% to 90%) ---
.measure tran trise_1 trig V(OUT)=0.5 rise=1 targ V(OUT)=4.5 rise=1
.measure tran trise_2 trig V(OUT)=0.5 rise=2 targ V(OUT)=4.5 rise=2
.measure tran trise_3 trig V(OUT)=0.5 rise=3 targ V(OUT)=4.5 rise=3
.measure tran trise_4 trig V(OUT)=0.5 rise=4 targ V(OUT)=4.5 rise=4

* --- Fall Times (90% to 10%) ---
.measure tran tfall_1 trig V(OUT)=4.5 fall=1 targ V(OUT)=0.5 fall=1
.measure tran tfall_2 trig V(OUT)=4.5 fall=2 targ V(OUT)=0.5 fall=2
.measure tran tfall_3 trig V(OUT)=4.5 fall=3 targ V(OUT)=0.5 fall=3
.measure tran tfall_4 trig V(OUT)=4.5 fall=4 targ V(OUT)=0.5 fall=4

* --- Nested Max Calculations (Fixes the Syntax Error) ---
.measure tran max_r12 param max(trise_1, trise_2)
.measure tran max_r34 param max(trise_3, trise_4)
.measure tran max_rise param max(max_r12, max_r34)

.measure tran max_f12 param max(tfall_1, tfall_2)
.measure tran max_f34 param max(tfall_3, tfall_4)
.measure tran max_fall param max(max_f12, max_f34)

.END
