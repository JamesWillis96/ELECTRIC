*** SPICE deck for cell Carryout_V3{lay} from library HW5_NOR
*** Created on Sun Apr 05, 2026 14:05:57
*** Last revised on Mon Apr 06, 2026 11:57:19
*** Written on Tue Apr 07, 2026 15:25:31 by Electric VLSI Design System, version 9.07
*** Layout tech: mocmos, foundry MOSIS
*** UC SPICE *** , MIN_RESIST 4.0, MIN_CAPAC 0.1FF
***    P-Active:	areacap=0.9FF/um^2,	edgecap=0.0FF/um,	res=2.5ohms/sq
***    N-Active:	areacap=0.9FF/um^2,	edgecap=0.0FF/um,	res=3.0ohms/sq
***    Polysilicon-1:	areacap=0.1467FF/um^2,	edgecap=0.0608FF/um,	res=6.2ohms/sq
***    Polysilicon-2:	areacap=1.0FF/um^2,	edgecap=0.0FF/um,	res=50.0ohms/sq
***    Transistor-Poly:	areacap=0.09FF/um^2,	edgecap=0.0FF/um,	res=2.5ohms/sq
***    Poly-Cut:	areacap=0.0FF/um^2,	edgecap=0.0FF/um,	res=2.2ohms/sq
***    Active-Cut:	areacap=0.0FF/um^2,	edgecap=0.0FF/um,	res=2.5ohms/sq
***    Metal-1:	areacap=0.1209FF/um^2,	edgecap=0.1104FF/um,	res=0.078ohms/sq
***    Via1:	areacap=0.0FF/um^2,	edgecap=0.0FF/um,	res=1.0ohms/sq
***    Metal-2:	areacap=0.0843FF/um^2,	edgecap=0.0974FF/um,	res=0.078ohms/sq
***    Via2:	areacap=0.0FF/um^2,	edgecap=0.0FF/um,	res=0.9ohms/sq
***    Metal-3:	areacap=0.0843FF/um^2,	edgecap=0.0974FF/um,	res=0.078ohms/sq
***    Via3:	areacap=0.0FF/um^2,	edgecap=0.0FF/um,	res=0.8ohms/sq
***    Metal-4:	areacap=0.0843FF/um^2,	edgecap=0.0974FF/um,	res=0.078ohms/sq
***    Via4:	areacap=0.0FF/um^2,	edgecap=0.0FF/um,	res=0.8ohms/sq
***    Metal-5:	areacap=0.0843FF/um^2,	edgecap=0.0974FF/um,	res=0.078ohms/sq
***    Via5:	areacap=0.0FF/um^2,	edgecap=0.0FF/um,	res=0.8ohms/sq
***    Metal-6:	areacap=0.0423FF/um^2,	edgecap=0.1273FF/um,	res=0.036ohms/sq
***    Hi-Res:	areacap=0.0FF/um^2,	edgecap=0.0FF/um,	res=1.0ohms/sq
* Model cards are described in this file:
.include 'C:\Users\jbwil\AMI0p5BSIM.txt'

*** TOP LEVEL CELL: Carryout_V3{lay}
Mnmos@0 net@12 A1#0nmos@0_poly-right gnd gnd N L=0.7U W=2.1U AS=4.073P AD=1.929P PS=8.137U PD=4.375U
Mnmos@1 OUT C1#1nmos@1_poly-right net@12 gnd N L=0.7U W=2.1U AS=1.929P AD=3.716P PS=4.375U PD=6.3U
Mnmos@2 net@16 C1#3nmos@2_poly-right OUT gnd N L=0.7U W=2.1U AS=3.716P AD=1.929P PS=6.3U PD=4.375U
Mnmos@3 gnd B1#1nmos@3_poly-right net@16 gnd N L=0.7U W=2.1U AS=1.929P AD=4.073P PS=4.375U PD=8.137U
Mnmos@4 net@19 A1#3nmos@4_poly-right gnd gnd N L=0.7U W=2.1U AS=4.073P AD=1.929P PS=8.137U PD=4.375U
Mnmos@5 OUT B1#3nmos@5_poly-right net@19 gnd N L=0.7U W=2.1U AS=1.929P AD=3.716P PS=4.375U PD=6.3U
Mnmos@6 TRUEOUT OUT#12nmos@6_poly-right gnd gnd N L=0.7U W=1.05U AS=4.073P AD=3.491P PS=8.137U PD=7.7U
Mpmos@0 net@4 A1 vdd vdd P L=0.7U W=2.8U AS=5.176P AD=2.419P PS=9.188U PD=5.075U
Mpmos@1 OUT C1 net@4 vdd P L=0.7U W=2.8U AS=2.419P AD=3.716P PS=5.075U PD=6.3U
Mpmos@2 net@7 C1#2pmos@2_poly-left OUT vdd P L=0.7U W=2.8U AS=3.716P AD=2.419P PS=6.3U PD=5.075U
Mpmos@3 vdd B1 net@7 vdd P L=0.7U W=2.8U AS=2.419P AD=5.176P PS=5.075U PD=9.188U
Mpmos@4 net@10 A1#2pmos@4_poly-left vdd vdd P L=0.7U W=2.8U AS=5.176P AD=2.419P PS=9.188U PD=5.075U
Mpmos@5 OUT B1#2pmos@5_poly-left net@10 vdd P L=0.7U W=2.8U AS=2.419P AD=3.716P PS=5.075U PD=6.3U
Mpmos@6 TRUEOUT OUT#10pmos@6_poly-left vdd vdd P L=0.7U W=1.4U AS=5.176P AD=3.491P PS=9.188U PD=7.7U
** Extracted Parasitic Capacitors ***
C0 OUT 0 8.718fF
C1 TRUEOUT 0 2.935fF
C2 A1#0nmos@0_poly-right 0 0.236fF
C3 C1#1nmos@1_poly-right 0 0.157fF
C4 C1#3nmos@2_poly-right 0 0.157fF
C5 B1#1nmos@3_poly-right 0 0.157fF
C6 A1#3nmos@4_poly-right 0 0.275fF
C7 B1#3nmos@5_poly-right 0 0.157fF
C8 OUT#12nmos@6_poly-right 0 0.105fF
C9 A1_2 0 0.236fF
C10 C1 0 0.334fF
C11 C1#2pmos@2_poly-left 0 0.334fF
C12 A1#5pin@12_polysilicon-1 0 0.322fF
C13 A1#6pin@13_polysilicon-1 0 0.322fF
C14 B1#4pin@14_polysilicon-1 0 0.288fF
C15 B1#5pin@15_polysilicon-1 0 0.288fF
C16 B1#2pmos@5_poly-left 0 0.275fF
C17 OUT#11pin@19_polysilicon-1 0 0.36fF
C18 A1 0 0.118fF
C19 B1 0 0.275fF
C20 A1#2pmos@4_poly-left 0 0.157fF
C21 OUT#10pmos@6_poly-left 0 0.118fF
** Extracted Parasitic Resistors ***
R0 A1#0nmos@0_poly-right A1_2 9.3
R1 A1_2 A1 9.3
R2 C1 C1##0 9.3
C22 C1##0 0 0.157fF
R3 C1##0 C1#1nmos@1_poly-right 9.3
R4 C1#2pmos@2_poly-left C1#2pmos@2_poly-left##0 9.3
C23 C1#2pmos@2_poly-left##0 0 0.157fF
R5 C1#2pmos@2_poly-left##0 C1#3nmos@2_poly-right 9.3
R6 B1 B1##0 9.3
C24 B1##0 0 0.157fF
R7 B1##0 B1#1nmos@3_poly-right 9.3
R8 A1#2pmos@4_poly-left A1#2pmos@4_poly-left##0 9.3
C25 A1#2pmos@4_poly-left##0 0 0.157fF
R9 A1#2pmos@4_poly-left##0 A1#3nmos@4_poly-right 9.3
R10 B1#2pmos@5_poly-left B1#2pmos@5_poly-left##0 9.3
C26 B1#2pmos@5_poly-left##0 0 0.157fF
R11 B1#2pmos@5_poly-left##0 B1#3nmos@5_poly-right 9.3
R12 C1 C1##0 9.3
C27 C1##0 0 0.177fF
R13 C1##0 C1##1 9.3
C28 C1##1 0 0.177fF
R14 C1##1 C1#2pmos@2_poly-left 9.3
R15 A1#3nmos@4_poly-right A1#5pin@12_polysilicon-1 9.3
R16 A1#5pin@12_polysilicon-1 A1#5pin@12_polysilicon-1##0 8.956
C29 A1#5pin@12_polysilicon-1##0 0 0.204fF
R17 A1#5pin@12_polysilicon-1##0 A1#5pin@12_polysilicon-1##1 8.956
C30 A1#5pin@12_polysilicon-1##1 0 0.204fF
R18 A1#5pin@12_polysilicon-1##1 A1#5pin@12_polysilicon-1##2 8.956
C31 A1#5pin@12_polysilicon-1##2 0 0.204fF
R19 A1#5pin@12_polysilicon-1##2 A1#5pin@12_polysilicon-1##3 8.956
C32 A1#5pin@12_polysilicon-1##3 0 0.204fF
R20 A1#5pin@12_polysilicon-1##3 A1#5pin@12_polysilicon-1##4 8.956
C33 A1#5pin@12_polysilicon-1##4 0 0.204fF
R21 A1#5pin@12_polysilicon-1##4 A1#5pin@12_polysilicon-1##5 8.956
C34 A1#5pin@12_polysilicon-1##5 0 0.204fF
R22 A1#5pin@12_polysilicon-1##5 A1#5pin@12_polysilicon-1##6 8.956
C35 A1#5pin@12_polysilicon-1##6 0 0.204fF
R23 A1#5pin@12_polysilicon-1##6 A1#5pin@12_polysilicon-1##7 8.956
C36 A1#5pin@12_polysilicon-1##7 0 0.204fF
R24 A1#5pin@12_polysilicon-1##7 A1#6pin@13_polysilicon-1 8.956
R25 A1#6pin@13_polysilicon-1 A1#0nmos@0_poly-right 9.3
R26 B1 B1#4pin@14_polysilicon-1 9.3
R27 B1#4pin@14_polysilicon-1 B1#4pin@14_polysilicon-1##0 8.06
C37 B1#4pin@14_polysilicon-1##0 0 0.17fF
R28 B1#4pin@14_polysilicon-1##0 B1#4pin@14_polysilicon-1##1 8.06
C38 B1#4pin@14_polysilicon-1##1 0 0.17fF
R29 B1#4pin@14_polysilicon-1##1 B1#4pin@14_polysilicon-1##2 8.06
C39 B1#4pin@14_polysilicon-1##2 0 0.17fF
R30 B1#4pin@14_polysilicon-1##2 B1#4pin@14_polysilicon-1##3 8.06
C40 B1#4pin@14_polysilicon-1##3 0 0.17fF
R31 B1#4pin@14_polysilicon-1##3 B1#5pin@15_polysilicon-1 8.06
R32 B1#5pin@15_polysilicon-1 B1#2pmos@5_poly-left 9.3
R33 OUT#10pmos@6_poly-left OUT#10pmos@6_poly-left##0 6.975
C41 OUT#10pmos@6_poly-left##0 0 0.118fF
R34 OUT#10pmos@6_poly-left##0 OUT#11pin@19_polysilicon-1 6.975
R35 OUT#11pin@19_polysilicon-1 OUT#11pin@19_polysilicon-1##0 6.2
C42 OUT#11pin@19_polysilicon-1##0 0 0.105fF
R36 OUT#11pin@19_polysilicon-1##0 OUT#12nmos@6_poly-right 6.2
R37 OUT#11pin@19_polysilicon-1 OUT#11pin@19_polysilicon-1##0 7.233
C43 OUT#11pin@19_polysilicon-1##0 0 0.137fF
R38 OUT#11pin@19_polysilicon-1##0 OUT#11pin@19_polysilicon-1##1 7.233
C44 OUT#11pin@19_polysilicon-1##1 0 0.137fF
R39 OUT#11pin@19_polysilicon-1##1 OUT 7.233

*** POWER SUPPLIES
Vdd vdd 0 DC 5V
Vgnd gnd 0 DC 0V

*** TEST CASE 1: WORST CASE FALL TIME
*** Carryout falls when both A1 and B1 are low, C1 is high
*VA1 A1 0 PULSE(5V 0V 1ns 10ps 10ps 2ns 10ns)
*VB1 B1 0 PULSE(5V 0V 1ns 10ps 10ps 2ns 10ns)
*VC1 C1 0 DC 5V

*** TRANSIENT ANALYSIS - 10ns window with 1ps resolution
*.TRAN 0 4ns 0 1ps

*** MEASUREMENTS FOR WORST CASE FALL TIME
*.MEAS TRAN tpd_fall_case1 TRIG V(A1) VAL=2.5V FALL=1 TARG V(OUT) VAL=2.5V FALL=1
*.MEAS TRAN fall_time_case1 TRIG V(OUT) VAL=4.5V FALL=1 TARG V(OUT) VAL=0.5V FALL=1
*.MEAS TRAN input_fall_time_A1 TRIG V(A1) VAL=4.5V FALL=1 TARG V(A1) VAL=0.5V FALL=1
*.MEAS TRAN output_fall_delay TRIG V(A1) VAL=2.5V FALL=1 TARG V(OUT) VAL=2.5V FALL=1

*** TEST CASE 2: WORST CASE RISE TIME
*** Carryout rises when at least one of A1 or B1 is high
VA1 A1 0 PULSE(0V 5V 1ns 10ps 10ps 2ns 10ns)
VB1 B1 0 DC 0V
VC1 C1 0 DC 5V

*** TRANSIENT ANALYSIS
.TRAN 0 4ns 0 1ps

*** MEASUREMENTS FOR WORST CASE RISE TIME
.MEAS TRAN tpd_rise_case2  TRIG V(A1) VAL=2.5V RISE=1  TARG V(OUT) VAL=2.5V RISE=1
.MEAS TRAN rise_time_case2 TRIG V(OUT) VAL=0.5V RISE=1  TARG V(OUT) VAL=4.5V RISE=1
.MEAS TRAN input_rise_time_A1 TRIG V(A1) VAL=0.5V RISE=1  TARG V(A1) VAL=4.5V RISE=1
.MEAS TRAN output_rise_delay TRIG V(A1) VAL=2.5V RISE=1  TARG V(OUT) VAL=2.5V RISE=1

.END
